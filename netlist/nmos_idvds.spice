*NMOS Id-Vds characterization

.lib /foss/pdks/sky130A/libs.tech/ngspice/sky130.lib.spice tt

Vgs gate 0 1.0
Vds drain 0 0
XM1 drain gate 0 0 sky130_fd_pr__nfet_01v8 W=1 L=0.15

.control

dc Vds 0 1.8 0.01 Vgs 0.6 1.2 0.2
plot -i(Vds) vs v(drain)
write ../data/nmos_idvds.raw
.endc
.end
