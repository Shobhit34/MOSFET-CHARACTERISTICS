* 5-stage ring oscillator
.lib /foss/pdks/sky130A/libs.tech/ngspice/sky130.lib.spice tt

Vdd vdd 0 1.8

XM1p n1 n5 vdd vdd sky130_fd_pr__pfet_01v8 W=2 L=0.15
XM1n n1 n5 0 0 sky130_fd_pr__nfet_01v8 W=1 L=0.15

XM2p n2 n1 vdd vdd sky130_fd_pr__pfet_01v8 W=2 L=0.15
XM2n n2 n1 0 0 sky130_fd_pr__nfet_01v8 W=1 L=0.15

XM3p n3 n2 vdd vdd sky130_fd_pr__pfet_01v8 W=2 L=0.15
XM3n n3 n2 0 0 sky130_fd_pr__nfet_01v8 W=1 L=0.15

XM4p n4 n3 vdd vdd sky130_fd_pr__pfet_01v8 W=2 L=0.15
XM4n n4 n3 0 0 sky130_fd_pr__nfet_01v8 W=1 L=0.15

XM5p n5 n4 vdd vdd sky130_fd_pr__pfet_01v8 W=2 L=0.15
XM5n n5 n4 0 0 sky130_fd_pr__nfet_01v8 W=1 L=0.15

.control
tran 10p 10n
plot v(n1) v(n2) v(n3)
write ../data/ring_osc.raw
.endc

.end
