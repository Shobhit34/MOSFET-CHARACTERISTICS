*pmos Id-Vds characterization
.lib /foss/pdks/sky130A/libs.tech/ngspice/sky130.lib.spice tt

Vdd vdd 0 1.8
Vgate gate 0 1.2
Vdrain drain 0 1.8
XM1 drain gate vdd vdd sky130_fd_pr__pfet_01v8 W=2 L=0.15

.control
dc Vdrain 1.8 0 -0.01 Vgate 1.2 0.6 -0.2
plot -i(Vdrain) vs v(drain)
write ../data/pmos_idvds.raw
.endc
.end
